* NGSPICE file created from ihp130_VinjDec2_to_4.ext - technology: ihp-sg13g2

.subckt ihp130_VinjNOR3 Input[0] Input[1] Input[2] VINJ GND Output
M0 a_n114_408# Input[0] a_n398_408# VINJ sg13_hv_pmos ad=0.1869p pd=1.31u as=0.1869p ps=1.31u w=0.42u l=0.53u
**devattr s=5712,304 d=5712,304
M1 GND Input[1] Output GND sg13_hv_nmos ad=0.46973p pd=3.34667u as=0.2383p ps=2.33u w=0.42u l=0.5u
**devattr s=5712,304 d=5712,304
M2 a_n398_408# Input[2] VINJ VINJ sg13_hv_pmos ad=0.1869p pd=1.31u as=0.3549p ps=2.64u w=0.42u l=0.53u
**devattr s=5712,304 d=5712,304
M3 GND Input[0] Output GND sg13_hv_nmos ad=0.46973p pd=3.34667u as=0.2383p ps=2.33u w=0.42u l=0.5u
**devattr s=5712,304 d=5712,304
M4 Output Input[1] a_n114_408# VINJ sg13_hv_pmos ad=0.2383p pd=2.33u as=0.1869p ps=1.31u w=0.42u l=0.53u
**devattr s=5712,304 d=5712,304
M5 Output Input[2] GND GND sg13_hv_nmos ad=0.2383p pd=2.33u as=0.46973p ps=3.34667u w=0.42u l=0.5u
**devattr s=5712,304 d=5712,304
.ends

.subckt ihp130_VinjInv2 Output Input VINJ GND
M0 Output Input VINJ VINJ sg13_hv_pmos ad=0.4032p pd=2.34u as=0.3516p ps=2.68u w=0.42u l=0.53u
**devattr s=5712,304 d=5712,304
M1 GND Input Output GND sg13_hv_nmos ad=0.348p pd=2.66u as=0.4032p ps=2.34u w=0.42u l=0.53u
**devattr s=5712,304 d=5712,304
.ends

.subckt ihp130_VinjDec2_to_4 Input[0] Input[1] ENABLE VINJ GND Output[0] Output[1]
+ Output[2] Output[3]
Xihp130_VinjNOR3_0 Input[0] Input[1] ihp130_VinjInv2_2/Output VINJ GND Output[0] ihp130_VinjNOR3
Xihp130_VinjNOR3_1 Input[0] ihp130_VinjInv2_1/Output ihp130_VinjInv2_2/Output VINJ
+ GND Output[1] ihp130_VinjNOR3
Xihp130_VinjNOR3_2 ihp130_VinjInv2_0/Output Input[1] ihp130_VinjInv2_2/Output VINJ
+ GND Output[2] ihp130_VinjNOR3
Xihp130_VinjNOR3_3 ihp130_VinjInv2_0/Output ihp130_VinjInv2_1/Output ihp130_VinjInv2_2/Output
+ VINJ GND Output[3] ihp130_VinjNOR3
Xihp130_VinjInv2_0 ihp130_VinjInv2_0/Output Input[0] VINJ GND ihp130_VinjInv2
Xihp130_VinjInv2_1 ihp130_VinjInv2_1/Output Input[1] VINJ GND ihp130_VinjInv2
Xihp130_VinjInv2_2 ihp130_VinjInv2_2/Output ENABLE VINJ GND ihp130_VinjInv2
.ends
