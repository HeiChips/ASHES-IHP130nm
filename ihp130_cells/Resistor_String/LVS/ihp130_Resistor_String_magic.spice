* NGSPICE file created from ihp130_Resistor_String.ext - technology: ihp-sg13g2

.subckt ihp130_Resistor_String VREFout VREFin Node[0] Node[1] Node[2] Node[3]
X0 Node[0] VREFin rsil l=10u w=0.59u
X1 Node[2] a_4048_180# rsil l=10u w=0.59u
X2 Node[1] a_4048_810# rsil l=10u w=0.59u
X3 Node[3] a_4048_180# rsil l=10u w=0.59u
X4 Node[1] a_4048_494# rsil l=10u w=0.59u
X5 Node[2] a_4048_494# rsil l=10u w=0.59u
X6 Node[0] a_4048_810# rsil l=10u w=0.59u
X7 Node[3] VREFout rsil l=10u w=0.59u
.ends
