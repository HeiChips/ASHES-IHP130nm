** sch_path: /home/lhanks6/ASHES-IHP130nm/ihp130_cells/Resistor_String/ihp130_resistor_string.sch
.subckt ihp130_resistor_string VREFout VREFin Node[3] Node[2] Node[1] Node[0]
*.PININFO VREFout:B VREFin:B Node[3:0]:O
XR8 Node[0] VREFin rsil w=.59e-6 l=10e-6 m=1 b=0
XR1 net1 Node[0] rsil w=.59e-6 l=10e-6 m=1 b=0
XR2 Node[1] net1 rsil w=.59e-6 l=10e-6 m=1 b=0
XR3 net2 Node[1] rsil w=.59e-6 l=10e-6 m=1 b=0
XR4 Node[2] net2 rsil w=.59e-6 l=10e-6 m=1 b=0
XR5 net3 Node[2] rsil w=.59e-6 l=10e-6 m=1 b=0
XR6 Node[3] net3 rsil w=.59e-6 l=10e-6 m=1 b=0
XR7 VREFout Node[3] rsil w=.59e-6 l=10e-6 m=1 b=0
.ends
